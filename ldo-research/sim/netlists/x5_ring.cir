* ring f
.include /home/user/abc/ldo-research/sim/models/180nm_bulk.pm
.subckt inv a y vdd
Mn y a 0 0 NMOS W=1u L=0.18u
Mp y a vdd vdd PMOS W=2.5u L=0.18u
Cn y 0 30f
.ends
Xr0 n0 n1 vdd inv
Xr1 n1 n2 vdd inv
Xr2 n2 n3 vdd inv
Xr3 n3 n4 vdd inv
Xr4 n4 n5 vdd inv
Xr5 n5 n6 vdd inv
Xr6 n6 n0 vdd inv
VDD vdd 0 1.7
.ic v(n0)=0
.control
tran 2p 40n 0 5p uic
wrdata /home/user/abc/ldo-research/sim/results/x5_ring.txt v(n0) v(vdd)
quit
.endc
.end
