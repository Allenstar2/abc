* x6
.include /home/user/abc/ldo-research/sim/models/180nm_bulk.pm

.subckt ldoA vin vout vref fb fbi
Ibias vin bn 1e-05
Mbn bn bn 0 0 NMOS W=4u L=1u
Mt tail bn 0 0 NMOS W=8u L=1u
M1 d1 fbi tail 0 NMOS W=20u L=1.0u
M2 ea vref tail 0 NMOS W=20u L=1.0u
M3 d1 d1 vin vin PMOS W=4u L=1.0u
M4 ea d1 vin vin PMOS W=4u L=1.0u
Mbn2 bp bn 0 0 NMOS W=4u L=1u
Mbp bp bp vin vin PMOS W=4u L=1u
Mcs pg bp vin vin PMOS W=20u L=1u
Mb 0 ea pg pg PMOS W=20u L=0.18u
Mp vout pg vin vin PMOS W=4000u L=0.18u
R1 vout fb 4000.0
R2 fb 0 4000.0
Cc vout ea 5e-12
Bff 0 pg I = 0.001*(V(vin)-1.8)
.ends

VIN vin 0 DC 1.8 AC 1
VREF vref 0 0.8
X1 vin vout vref fb fb ldoA
CL vout 0 1e-10
IL vout 0 DC 0.1
.control
ac dec 20 10 1e9
wrdata /home/user/abc/ldo-research/sim/results/x6.txt v(vout)
quit
.endc
.end
