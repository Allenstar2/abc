* s17_dc
.include /home/user/abc/ldo-research/sim/results/tmp/model_SSlikeVth50mVTox5.pm
.options temp=125 reltol=1e-4 abstol=1e-12 vntol=1e-7

.subckt ldoA vin vout vref fb fbi
Ibias vin bn 1e-05
Mbn bn bn 0 0 NMOS W=4u L=1u
Mt tail bn 0 0 NMOS W=8u L=1u
M1 d1 fbi tail 0 NMOS W=20u L=1.0u
M2 ea vref tail 0 NMOS W=20u L=1.0u
M3 d1 d1 vin vin PMOS W=4u L=1.0u
M4 ea d1 vin vin PMOS W=4u L=1.0u
Mbn2 bp bn 0 0 NMOS W=4u L=1u
Mbp bp bp vin vin PMOS W=4u L=1u
Mcs pg bp vin vin PMOS W=20u L=1u
Mb 0 ea pg pg PMOS W=20u L=0.18u
Mp vout pg vin vin PMOS W=4000u L=0.18u
R1 vout fb 3428.5714285714284
R2 fb 0 4571.428571428572
Cc vout ea 5e-12
.ends

VIN vin 0 1.8
VREF vref 0 0.8
X1 vin vout vref fb fb ldoA
IL vout 0 DC 0.1
.control
dc VIN 1.3 1.98 0.002
wrdata /home/user/abc/ldo-research/sim/results/s17_dc.txt v(vout)
quit
.endc
.end
