* nmos load density
.include /home/user/abc/ldo-research/sim/models/180nm_bulk.pm
VD d 0 1.6
VG g 0 1.8
M1 d g 0 0 NMOS W=100u L=0.18u
.control
op
print -i(VD)
quit
.endc
.end
