* pass device sizing
.include /home/user/abc/ldo-research/sim/models/180nm_bulk.pm
VS s 0 1.8
VD d 0 1.6
VG g 0 0
M1 d g s s PMOS W=1000u L=0.18u
.control
dc VG 0 1.0 0.01
wrdata /home/user/abc/ldo-research/sim/results/dc_pass_idvg.txt i(VS)
quit
.endc
.end
