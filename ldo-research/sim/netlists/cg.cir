* cgate
.include /home/user/abc/ldo-research/sim/models/180nm_bulk.pm
VS s 0 1.8
VD d 0 1.6
VG g0 0 0.9
LG g0 g 1e6
IAC 0 g DC 0 AC 1
M1 d g s s PMOS W=4000u L=0.18u
.control
ac lin 2 1e5 2e5
let c = imag(1/v(g))/(2*3.14159265*frequency)
wrdata /home/user/abc/ldo-research/sim/results/cg.txt c
quit
.endc
.end
