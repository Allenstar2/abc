* bsim ver
.include /home/user/abc/ldo-research/sim/results/tmp/model_v330.pm
VD d 0 0.9
VG g 0 0.7
M1 d g 0 0 NMOS W=10u L=1u
.control
op
print @m1[gm] @m1[gds] @m1[id]
quit
.endc
.end
