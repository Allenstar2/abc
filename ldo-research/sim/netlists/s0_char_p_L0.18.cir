* p_L0.18
.include /home/user/abc/ldo-research/sim/models/180nm_bulk.pm
VS s 0 1.8
VD d 0 1.2
VG g 0 1.2
M1 d g s s PMOS W=1.7999999999999998u L=0.18u
.save @m1[id] @m1[gm] @m1[gds] @m1[vth]
.control
dc VG 1.6 0.6 -0.005
wrdata /home/user/abc/ldo-research/sim/results/dc_p_L0.18_vgs.txt @m1[id] @m1[gm] @m1[gds] @m1[vth]
alter VG 1.2
dc VD 1.75 0.0 -0.01 VG 1.3 1.0 -0.1
wrdata /home/user/abc/ldo-research/sim/results/dc_p_L0.18_vds.txt @m1[id] @m1[gm] @m1[gds]
quit
.endc
.end
