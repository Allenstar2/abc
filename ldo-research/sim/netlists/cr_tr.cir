* cr_tr
.include /home/user/abc/ldo-research/sim/results/tmp/model_FSlikeVthn50Vthp50.pm
.options temp=125 reltol=1e-4 abstol=1e-12 vntol=1e-7

.subckt ldoA vin vout vref fb fbi
Ibias vin bn 1e-05
Mbn bn bn 0 0 NMOS W=4u L=1u
Mt tail bn 0 0 NMOS W=8u L=1u
M1 d1 fbi tail 0 NMOS W=20u L=1.0u
M2 ea vref tail 0 NMOS W=20u L=1.0u
M3 d1 d1 vin vin PMOS W=4u L=1.0u
M4 ea d1 vin vin PMOS W=4u L=1.0u
Mbn2 bp bn 0 0 NMOS W=4u L=1u
Mbp bp bp vin vin PMOS W=4u L=1u
Mcs pg bp vin vin PMOS W=20u L=1u
Mb 0 ea pg pg PMOS W=20u L=0.18u
Mp vout pg vin vin PMOS W=4000u L=0.18u
R1 vout fb 4000.0
R2 fb 0 4000.0
Cc vout ea 2e-11
.ends

VIN vin 0 DC 1.8
VREF vref 0 0.8
X1 vin vout vref fb fb ldoA
CL vout ncl 1e-09
RESR ncl 0 1e-06
IL vout 0 PWL(0 0 2e-06 0 3e-06 0.1 9e-06 0.1 1e-05 0)

.control
tran 2e-09 1.6000000000000003e-05 0 1e-08
wrdata /home/user/abc/ldo-research/sim/results/cr_tr_tr.txt v(vout) v(x1.pg) v(x1.ea)
quit
.endc
.end
