* rep_xcheck
.include /home/user/abc/ldo-research/sim/models/180nm_bulk.pm
.options reltol=1e-4 abstol=1e-12 vntol=1e-7

.subckt ldoB vin vout fb pg ea
Ibias vin bn 10u
Mbn bn bn 0 0 NMOS W=4u L=1u
Mt tail bn 0 0 NMOS W=8u L=1u
M1 d1 fb tail 0 NMOS W=20u L=1u
M2 ea vref tail 0 NMOS W=20u L=1u
VREF vref 0 0.8
M3 d1 d1 vin vin PMOS W=4u L=1u
M4 ea d1 vin vin PMOS W=4u L=1u
Mbn2 bp bn 0 0 NMOS W=4u L=1u
Mbp bp bp vin vin PMOS W=4u L=1u
Mcs pg bp vin vin PMOS W=20u L=1u
Mb 0 ea pg pg PMOS W=20u L=0.18u
Mp vout pg vin vin PMOS W=2400u L=0.18u
R1 vout fb 4k
R2 fb 0 4k
Cc vout ea 5e-12
.ends

VIN vin 0 1.8
X1 vin vout fb pg ea ldoB
CL vout 0 100p
IL vout 0 PWL(0 95m 2e-06 95m 2.1e-06 0.005)
Vg1 g1 0 PWL(0 0 2.8000000000000003e-06 0 3.1000000000000004e-06 1.8)
Ms1 vout g1 vin vin PMOS W=130u L=0.18u
Vg2 g2 0 PWL(0 0 2.7e-06 0 3e-06 1.8)
Ms2 vout g2 vin vin PMOS W=130u L=0.18u
Vg3 g3 0 PWL(0 0 2.6e-06 0 2.9e-06 1.8)
Ms3 vout g3 vin vin PMOS W=130u L=0.18u
Vg4 g4 0 PWL(0 0 2.5e-06 0 2.8000000000000003e-06 1.8)
Ms4 vout g4 vin vin PMOS W=130u L=0.18u
Vg5 g5 0 PWL(0 0 2.4e-06 0 2.7e-06 1.8)
Ms5 vout g5 vin vin PMOS W=130u L=0.18u
Vg6 g6 0 PWL(0 0 2.3e-06 0 2.6e-06 1.8)
Ms6 vout g6 vin vin PMOS W=130u L=0.18u
Vg7 g7 0 PWL(0 0 2.2e-06 0 2.5e-06 1.8)
Ms7 vout g7 vin vin PMOS W=130u L=0.18u
Vg8 g8 0 1.8
Ms8 vout g8 vin vin PMOS W=130u L=0.18u
.control
tran 0.2n 4.5u 0 0.5n
wrdata /tmp/claude-0/-home-user/24b1423c-959f-5794-9f98-bbcbade8908e/scratchpad/review_r3c/res/rep_xcheck.txt v(vout) v(pg) v(ea)
quit
.endc
.end
