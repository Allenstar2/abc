* rep_N1000_Cc3_10mA_loopgain
.include /home/user/abc/ldo-research/sim/models/180nm_bulk.pm
.options temp=27 reltol=1e-4 abstol=1e-12 vntol=1e-7

.subckt ldo vin vdda vout vref fb fbi
Ibias vdda bn 1e-05
Mbn bn bn 0 0 NMOS W=4u L=1u
Mt tail bn 0 0 NMOS W=8u L=1u
M1 d1 vref tail 0 NMOS W=20u L=1u
M2 ea fbi tail 0 NMOS W=20u L=1u
M3 d1 d1 vdda vdda PMOS W=4u L=1u
M4 ea d1 vdda vdda PMOS W=4u L=1u
Cc ea 0 3e-12
Mn vin ea vout 0 NMOS W=1000u L=0.18u
R1 vout fb 1000.0
R2 fb 0 4000.0
.ends
VIN vin 0 DC 1.8 AC 0
Rtie vdda vin 1e-3
VREF vref 0 0.8
X1 vin vdda vout vref fb fbi ldo
Lbrk fb fbi 1e9
Cbrk fbi acs 1
VAC acs 0 DC 0 AC 1
CL vout 0 1e-10
IL vout 0 DC 0.01
.control
ac dec 50 10 3e9
let T = -v(fb)/v(fbi)
wrdata /tmp/claude-0/-home-user/24b1423c-959f-5794-9f98-bbcbade8908e/scratchpad/review_r3c/res/rep_N1000_Cc3_10mA_loopgain_T.txt T
quit
.endc
.end
