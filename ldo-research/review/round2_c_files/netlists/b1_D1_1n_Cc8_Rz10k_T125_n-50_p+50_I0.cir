* b1_D1_1n_Cc8_Rz10k_T125_n-50_p+50_I0
.include /tmp/claude-0/-home-user/24b1423c-959f-5794-9f98-bbcbade8908e/scratchpad/review_r2c/models/ptm_n-50_p+50.pm
.options temp=125 reltol=1e-5 abstol=1e-13 vntol=1e-8
Ibias vin bn 10u
Mbn bn bn 0 0 NMOS W=4u L=1u
Mt tail bn 0 0 NMOS W=8u L=1u
M1 d1 fbi tail 0 NMOS W=20u L=1u
M2 ea vref tail 0 NMOS W=20u L=1u
M3 d1 d1 vin vin PMOS W=4u L=1u
M4 ea d1 vin vin PMOS W=4u L=1u
Mbn2 bp bn 0 0 NMOS W=4u L=1u
Mbp bp bp vin vin PMOS W=4u L=1u
Mcs pg bp vin vin PMOS W=20u L=1u
Mb 0 ea pg pg PMOS W=20u L=0.18u
Mp vout pg vin vin PMOS W=4000u L=0.18u
R1 vout fb 4000.0
R2 fb 0 4000.0
Rz vout ncz 10000.0
Cc ncz ea 8e-12

VIN vin 0 DC 1.8
VREF vref 0 0.8
Lbrk fb fbi 1e9
Cbrk fbi acs 1
VAC acs 0 DC 0 AC 1
CL vout 0 1e-09
IL vout 0 DC 0
.control
op
print v(vout) v(pg) v(ea) v(fb)
ac dec 50 10 1e10
wrdata /tmp/claude-0/-home-user/24b1423c-959f-5794-9f98-bbcbade8908e/scratchpad/review_r2c/res/b1_D1_1n_Cc8_Rz10k_T125_n-50_p+50_I0.txt v(fb) v(fbi)
quit
.endc
.end
