* a_tr_CS5_ldo_fm300k_A10m
.include /home/user/abc/ldo-research/sim/models/180nm_bulk.pm
.options reltol=1e-4
Ibias vin bn 10u
Mbn bn bn 0 0 NMOS W=4u L=1u
Mt tail bn 0 0 NMOS W=8u L=1u
M1 d1 fb tail 0 NMOS W=20u L=1u
M2 ea vref tail 0 NMOS W=20u L=1u
M3 d1 d1 vin vin PMOS W=4u L=1u
M4 ea d1 vin vin PMOS W=4u L=1u
Mbn2 bp bn 0 0 NMOS W=4u L=1u
Mbp bp bp vin vin PMOS W=4u L=1u
Mcs pg bp vin vin PMOS W=20u L=1u
Mb 0 ea pg pg PMOS W=20u L=0.18u
Mp vdd pg vin vin PMOS W=4000u L=0.18u
R1 vdd fb 4000.0
R2 fb 0 4000.0
Cc vdd ea 5e-12
VIN vin 0 DC 1.8 SIN(1.8 0.01 300000.0 2e-06)
VREF vref 0 0.8
CL vdd 0 100p
* 5-stage current-starved ring; bias from resistor to vdd
Rb vdd nb 20k
Mnb nb nb 0 0 NMOS W=2u L=0.5u
Mn2 pb nb 0 0 NMOS W=2u L=0.5u
Mpb pb pb vdd vdd PMOS W=5u L=0.5u
Mpc0 xp0 pb vdd vdd PMOS W=5u L=0.5u
Mps0 n1 n0 xp0 vdd PMOS W=2u L=0.18u
Mns0 n1 n0 xn0 0 NMOS W=1u L=0.18u
Mnc0 xn0 nb 0 0 NMOS W=2u L=0.5u
Cl0 n1 0 20f
Mpc1 xp1 pb vdd vdd PMOS W=5u L=0.5u
Mps1 n2 n1 xp1 vdd PMOS W=2u L=0.18u
Mns1 n2 n1 xn1 0 NMOS W=1u L=0.18u
Mnc1 xn1 nb 0 0 NMOS W=2u L=0.5u
Cl1 n2 0 20f
Mpc2 xp2 pb vdd vdd PMOS W=5u L=0.5u
Mps2 n3 n2 xp2 vdd PMOS W=2u L=0.18u
Mns2 n3 n2 xn2 0 NMOS W=1u L=0.18u
Mnc2 xn2 nb 0 0 NMOS W=2u L=0.5u
Cl2 n3 0 20f
Mpc3 xp3 pb vdd vdd PMOS W=5u L=0.5u
Mps3 n4 n3 xp3 vdd PMOS W=2u L=0.18u
Mns3 n4 n3 xn3 0 NMOS W=1u L=0.18u
Mnc3 xn3 nb 0 0 NMOS W=2u L=0.5u
Cl3 n4 0 20f
Mpc4 xp4 pb vdd vdd PMOS W=5u L=0.5u
Mps4 n0 n4 xp4 vdd PMOS W=2u L=0.18u
Mns4 n0 n4 xn4 0 NMOS W=1u L=0.18u
Mnc4 xn4 nb 0 0 NMOS W=2u L=0.5u
Cl4 n0 0 20f
.ic v(n0)=0
.control
tran 1e-11 9.686666666666667e-06 0 1e-11
wrdata /tmp/claude-0/-home-user/24b1423c-959f-5794-9f98-bbcbade8908e/scratchpad/review_r2c/res/a_tr_CS5_ldo_fm300k_A10m.txt v(n0) v(vdd)
quit
.endc
.end
