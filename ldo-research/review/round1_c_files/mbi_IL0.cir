* reviewer r1c
.include /home/user/abc/ldo-research/sim/models/180nm_bulk.pm
.options temp=27 reltol=1e-4 abstol=1e-12 vntol=1e-7

Ibias vin bn 10u
Mbn  bn bn 0 0 NMOS W=4u L=1u
Mt   tail bn 0 0 NMOS W=8u L=1u
M1   d1 fb tail 0 NMOS W=20u L=1u
M2   ea vref tail 0 NMOS W=20u L=1u
M3   d1 d1 vin vin PMOS W=4u L=1u
M4   ea d1 vin vin PMOS W=4u L=1u
Mbn2 bp bn 0 0 NMOS W=4u L=1u
Mbp  bp bp vin vin PMOS W=4u L=1u
Mcs  pg bp vin vin PMOS W=20u L=1u
Mb   0 ea pg pg PMOS W=20u L=0.18u
Mp   vout pg vin vin PMOS W=4000u L=0.18u
R1   r1t fb 4000.0
R2   fb 0 4000.0
Cc   vout ea 5e-12
CL   vout ncl 1e-10
RESR ncl 0 1e-6

VIN vin 0 DC 1.8
VREF vref 0 0.8
Vsa vout j DC 0
Vsb j r1t DC 0
Iinj 0 j DC 0 AC 1
IL vout 0 DC 0.0
.control
ac dec 40 1 1e10
wrdata mbi_IL0.txt i(Vsa) i(Vsb)
.endc
.end
